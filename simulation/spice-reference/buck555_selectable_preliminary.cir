* Selectable-output 555 buck: 15 V in -> 3.3 V / 5 V / 12 V (open loop)
* STATUS: written without access to LTspice -> NOT yet run there. Expect to fix small syntax/convergence items.
* Values come from the behavioural Python model (buck555_sim.py); re-trim RA/RB in LTspice under load.
*
* Pick a mode with .param MODE (1 = 3.3 V, 2 = 5 V, 3 = 12 V) or uncomment the .step line to run all three.

.param MODE=2
*.step param MODE list 1 2 3

* ---- timing network (E96). RA = charge resistor, RB = discharge resistor ----
.param RA = table(MODE, 1,1.5k, 2,2.8k, 3,8.06k)
.param RB = table(MODE, 1,9.53k, 2,8.25k, 3,3.09k)

V1   vin 0 15
* input decoupling (add real ESR if you want to see input ripple)
Cin  vin 0 100u Rser=0.05

* ---- 555 astable, diode steered ----
* charge:    VCC -> RA -> X -> D1 -> C1
* discharge: C1 -> D2 -> RB -> X -> (555 DIS pulls X to ~0 V)
RA   vin x {RA}
D1   x tc 1N4148
D2   tc y 1N4148
RB   y x {RB}
C1   tc 0 4.7n
C2   ctrl 0 10n
X555 0 tc out vin ctrl tc x vin NE555B
* pin order of NE555B: GND TRIG OUT RST CTRL THR DIS VCC

* ---- gate driver ----
R6   out nb 4.7k
Q1   gate nb 0 2N2222
R7   vin gate 1k
* optional gate clamp (see notes): 12 V zener from source to gate
* To clamp |Vgs|: insert Rg (330-470R) between Q1 collector and the gate node, then add
*DZ  gate vin DZ12   ; anode=gate, cathode=vin  (clamps |Vgs| at ~12 V)

* ---- power stage ----
* PMOS: drain, gate, source ordering in a .model M-device is D G S B
* Replace PFET_GEN with the FDS4435A model from your library (it is a subckt: X.. D G S ...) - check its pin order.
M1   sw gate vin vin PFET_GEN
D3   0 sw SS34
L1   sw lx 1m Rser=0.15
C3   lx 0 220u Rser=0.05
* note: lx is Vout (inductor DCR + COUT ESR are on the elements)
R5   lx 0 10
* Vout node name: lx

* ---- models ----
.model PFET_GEN VDMOS(pchan Vto=-2 Kp=6 Rd=0.012 Rs=0.008 Rg=3 Cgdmax=300p Cgdmin=50p Cgs=1.8n Cjo=250p Is=1e-10 mfg=generic)
.model SS34 D(Is=2e-6 N=1.1 Rs=0.03 Cjo=300p Bv=40 Ibv=1m)
.model DZ12 D(Is=1e-14 Bv=12 Ibv=1m)

* ---- 555 behavioural subcircuit ----
.subckt NE555B gnd trig out rst ctrl thr dis vcc
Rt1 vcc ctrl 5k
Rt2 ctrl nd  5k
Rt3 nd   gnd 5k
* comparators (1 = condition true)
Bhi  hi  gnd V = V(thr,gnd) > V(ctrl,gnd) ? 1 : 0
Blo  lo  gnd V = V(trig,gnd) < V(nd,gnd) ? 1 : 0
Brs  rs  gnd V = (V(hi,gnd) > 0.5 | V(rst,gnd) < 0.5) ? 1 : 0
* latch: reset dominant, set when trigger low
Bq   gnd q I = (V(rs,gnd) > 0.5) ? -V(q,gnd)/1k : ((V(lo,gnd) > 0.5) ? (1-V(q,gnd))/1k : 0)
Cq   q gnd 10p IC=0
* output: Vcc-1.7 V high, 0.1 V low, 100 ohm-ish output impedance
Bo   o gnd V = V(q,gnd) > 0.5 ? max(V(vcc,gnd)-1.7,0) : 0.1
Ro   o out 100
* discharge: conducts to ground while q is low
Bqb  qb gnd V = 1 - V(q,gnd)
Sd   dis gnd qb gnd SDIS
.model SDIS SW(Ron=15 Roff=1G Vt=0.5 Vh=-0.05)
.ends NE555B

* ---- analyses ----
* A. 555 only: probe V(tc), V(out)
* C. whole converter: V(out) V(gate) V(sw) V(lx) I(L1) Id(M1)
.tran 0 20m 0 50n
.options plotwinsize=0 numdgt=7
.save V(out) V(gate) V(sw) V(lx) V(tc) I(L1)
.end
